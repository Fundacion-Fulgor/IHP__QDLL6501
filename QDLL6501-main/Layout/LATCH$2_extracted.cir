* Extracted by KLayout with SG13G2 LVS runset on : 07/03/2026 02:05

.SUBCKT LATCH$2
M$1 A|V1|Y A|V2|Y VSS VSS sg13_lv_nmos L=0.13u W=0.74u AS=0.2516p AD=0.2516p
+ PS=2.16u PD=2.16u
M$2 A|V2|Y A|V1|Y VSS VSS sg13_lv_nmos L=0.13u W=0.74u AS=0.2516p AD=0.2516p
+ PS=2.16u PD=2.16u
M$3 A|V1|Y A|V2|Y VDD VDD sg13_lv_pmos L=0.13u W=1.12u AS=0.3808p AD=0.3808p
+ PS=2.92u PD=2.92u
M$4 A|V2|Y A|V1|Y VDD VDD sg13_lv_pmos L=0.13u W=1.12u AS=0.3808p AD=0.3808p
+ PS=2.92u PD=2.92u
.ENDS LATCH$2
