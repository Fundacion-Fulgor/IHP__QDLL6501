* Extracted by KLayout with SG13G2 LVS runset on : 07/03/2026 02:02

.SUBCKT LATCH VSS VDD A|Y A|Y$1
M$1 A|Y A|Y$1 VSS VSS sg13_lv_nmos L=0.13u W=0.74u AS=0.2516p AD=0.2516p
+ PS=2.16u PD=2.16u
M$2 A|Y$1 A|Y VSS VSS sg13_lv_nmos L=0.13u W=0.74u AS=0.2516p AD=0.2516p
+ PS=2.16u PD=2.16u
M$3 A|Y A|Y$1 VDD VDD sg13_lv_pmos L=0.13u W=1.12u AS=0.3808p AD=0.3808p
+ PS=2.92u PD=2.92u
M$4 A|Y$1 A|Y VDD VDD sg13_lv_pmos L=0.13u W=1.12u AS=0.3808p AD=0.3808p
+ PS=2.92u PD=2.92u
.ENDS LATCH
