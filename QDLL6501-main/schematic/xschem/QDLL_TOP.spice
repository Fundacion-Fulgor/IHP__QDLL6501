** sch_path: QDLL6501-main/schematic/xschem/QDLL_TOP.sch
.subckt QDLL_TOP VDD VSS IN1 OUT1 OUT2 IN2 CPOUT2 VCONT2 IN3 OUT3
*.iopin VDD
*.iopin VSS
*.ipin IN1
*.ipin IN2
*.opin OUT1
*.opin OUT2
*.opin CPOUT2
*.ipin VCONT2
*.opin OUT3
*.ipin IN3
x2 VDD IN1 net1 net3 VSS VCDL
x5 VDD IN2 net4 VCONT2 VSS VCDL
x1 VSS VDD net4 OUT2 DLine
x3 VSS VDD IN3 OUT3 DLine
x4 VSS VDD net1 OUT1 DLine
x6 VDD VSS IN2 net5 OUT2 PD
x7 VDD VSS IN1 net2 OUT1 PD
x8 net2 net3 VSS CP
x9 net5 CPOUT2 VSS CP
.ends

* expanding   symbol:  VCDL.sym # of pins=5
** sym_path: QDLL6501-main/schematic/xschem/VCDL.sym
** sch_path: QDLL6501-main/schematic/xschem/VCDL.sch
.subckt VCDL VDD VIN VOUT VCONT VSS
*.iopin VDD
*.iopin VSS
*.ipin VIN
*.ipin VCONT
*.opin VOUT
XM1 VOUT VIN net3 VSS sg13_lv_nmos w=2u l=0.13u ng=1 m=1 mm_ok=1
XM2 net3 VCONT VSS VSS sg13_lv_nmos w=3.5u l=0.18u ng=1 m=1 mm_ok=1
XM3 net1 VCONT VSS VSS sg13_lv_nmos w=2u l=0.25u ng=1 m=1 mm_ok=1
XM4 VOUT VIN net2 VDD sg13_lv_pmos w=4.46u l=0.13u ng=1 m=1 mm_ok=1
XM5 net2 net1 VDD VDD sg13_lv_pmos w=2.24u l=0.13u ng=1 m=1 mm_ok=1
XM6 net1 net1 VDD VDD sg13_lv_pmos w=2.24u l=0.13u ng=1 m=1 mm_ok=1
.ends

* expanding   symbol:  DLine.sym # of pins=4
** sym_path: QDLL6501-main/schematic/xschem/DLine.sym
** sch_path: QDLL6501-main/schematic/xschem/DLine.sch
.subckt DLine VSS VDD VIN VOUT
*.opin VOUT
*.ipin VIN
*.iopin VDD
*.iopin VSS
x2 net1 net4 VDD VSS sg13g2_inv_4
x3 net2 net1 VDD VSS sg13g2_inv_8
x4 VOUT net2 VDD VSS sg13g2_inv_16
x5 net3 VIN VDD VSS sg13g2_dlygate4sd3_1
x6 net4 net3 VDD VSS sg13g2_dlygate4sd2_1
.ends

* expanding   symbol:  PD.sym # of pins=5
** sym_path: QDLL6501-main/schematic/xschem/PD.sym
** sch_path: QDLL6501-main/schematic/xschem/PD.sch
.subckt PD VDD VSS PDIN1 PDOUT PDIN2
*.iopin VDD
*.iopin VSS
*.opin PDOUT
*.ipin PDIN1
*.ipin PDIN2
x1 PDOUT PDIN1 PDIN2 VDD VSS sg13g2_xor2_1
.ends

* expanding   symbol:  CP.sym # of pins=3
** sym_path: QDLL6501-main/schematic/xschem/CP.sym
** sch_path: QDLL6501-main/schematic/xschem/CP.sch
.subckt CP CPIN CPOUT VSS
*.iopin VSS
*.ipin CPIN
*.opin CPOUT
XC1 CPOUT VSS cap_cmim w=60e-6 l=20e-6 m=1 mm_ok=1
x1 CPOUT CPIN VSS RES
.ends

* expanding   symbol:  RES.sym # of pins=3
** sym_path: QDLL6501-main/schematic/xschem/RES.sym
** sch_path: QDLL6501-main/schematic/xschem/RES.sch
.subckt RES ROUT RIN VSS
*.ipin RIN
*.opin ROUT
*.iopin VSS
XR13 net1 RIN VSS rppd w=1e-6 l=10e-6 m=1 b=0 mm_ok=1
XR1 net2 net1 VSS rppd w=1e-6 l=10e-6 m=1 b=0 mm_ok=1
XR2 net3 net2 VSS rppd w=1e-6 l=10e-6 m=1 b=0 mm_ok=1
XR3 net4 net3 VSS rppd w=1e-6 l=10e-6 m=1 b=0 mm_ok=1
XR4 net5 net4 VSS rppd w=1e-6 l=10e-6 m=1 b=0 mm_ok=1
XR5 net6 net5 VSS rppd w=1e-6 l=10e-6 m=1 b=0 mm_ok=1
XR6 net7 net6 VSS rppd w=1e-6 l=10e-6 m=1 b=0 mm_ok=1
XR7 net8 net7 VSS rppd w=1e-6 l=10e-6 m=1 b=0 mm_ok=1
XR8 net9 net8 VSS rppd w=1e-6 l=10e-6 m=1 b=0 mm_ok=1
XR9 net10 net9 VSS rppd w=1e-6 l=10e-6 m=1 b=0 mm_ok=1
XR10 net11 net10 VSS rppd w=1e-6 l=10e-6 m=1 b=0 mm_ok=1
XR11 ROUT net11 VSS rppd w=1e-6 l=10e-6 m=1 b=0 mm_ok=1
.ends
