** sch_path: QDLL6501-main/schematic/xschem/DLineLP.sch
.subckt DLineLP VSS VDD VIN VOUT
*.opin VOUT
*.ipin VIN
*.iopin VDD
*.iopin VSS
x2 net1 net4 VDD VSS sg13g2_inv_2
x3 net2 net1 VDD VSS sg13g2_inv_4
x4 VOUT net2 VDD VSS sg13g2_inv_8
x5 net3 VIN VDD VSS sg13g2_dlygate4sd3_1
x6 net4 net3 VDD VSS sg13g2_dlygate4sd2_1
.ends
