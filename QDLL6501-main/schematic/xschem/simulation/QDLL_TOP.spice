** sch_path: /home/designer/designs/libs/IHP__MPC0349/dependencies/IHP__QDLL6501/QDLL6501-main/schematic/xschem/QDLL_TOP.sch
**.subckt QDLL_TOP VDD VSS IN1 OUT1 OUT2 IN2 CPOUT2 VCONT2 IN3 OUT3
*.ipin IN1
*.ipin IN2
*.opin OUT1
*.opin OUT2
*.opin CPOUT2
*.ipin VCONT2
*.opin OUT3
*.ipin IN3
*.iopin VDD
*.iopin VSS
x2 VDD IN1 net1 VCONT VSS VCDL
x5 VDD IN2 net3 VCONT2 VSS VCDL
x1 VSS VDD net3 OUT2 DLine
x3 VSS VDD IN3 OUT3 DLine
x4 VSS VDD net1 OUT1 DLine
x6 VDD VSS IN2 net4 OUT2 PD
x7 VDD VSS IN1 net2 OUT1 PD
x8 net2 VCONT VSS CP
x9 net4 CPOUT2 VSS CP
XC1 VDD VSS cap_cmim w=25.5e-6 l=6.99e-6 m=1 mm_ok=1
x10 VCONT VDD VSS sg13g2_antennanp
x11 VCONT2 VDD VSS sg13g2_antennanp
**.ends

* expanding   symbol:  VCDL.sym # of pins=5
** sym_path: /home/designer/designs/libs/IHP__MPC0349/dependencies/IHP__QDLL6501/QDLL6501-main/schematic/xschem/VCDL.sym
** sch_path: /home/designer/designs/libs/IHP__MPC0349/dependencies/IHP__QDLL6501/QDLL6501-main/schematic/xschem/VCDL.sch
.subckt VCDL VDD VIN VOUT VCONT VSS
*.iopin VDD
*.iopin VSS
*.ipin VIN
*.ipin VCONT
*.opin VOUT
XM1 VOUT VIN net3 VSS sg13_lv_nmos w=2u l=0.13u ng=1 m=1 mm_ok=1
XM2 net3 VCONT VSS VSS sg13_lv_nmos w=3.5u l=0.18u ng=1 m=1 mm_ok=1
XM3 net1 VCONT VSS VSS sg13_lv_nmos w=2u l=0.25u ng=1 m=1 mm_ok=1
XM4 VOUT VIN net2 VDD sg13_lv_pmos w=4.46u l=0.13u ng=1 m=1 mm_ok=1
XM5 net2 net1 VDD VDD sg13_lv_pmos w=2.24u l=0.13u ng=1 m=1 mm_ok=1
XM6 net1 net1 VDD VDD sg13_lv_pmos w=2.24u l=0.13u ng=1 m=1 mm_ok=1
.ends

* expanding   symbol:  DLine.sym # of pins=4
** sym_path: /home/designer/designs/libs/IHP__MPC0349/dependencies/IHP__QDLL6501/QDLL6501-main/schematic/xschem/DLine.sym
** sch_path: /home/designer/designs/libs/IHP__MPC0349/dependencies/IHP__QDLL6501/QDLL6501-main/schematic/xschem/DLine.sch
.subckt DLine VSS VDD VIN VOUT
*.opin VOUT
*.ipin VIN
*.iopin VDD
*.iopin VSS
x2 net1 net4 VDD VSS sg13g2_inv_4
x3 net2 net1 VDD VSS sg13g2_inv_8
x4 VOUT net2 VDD VSS sg13g2_inv_16
x5 net3 VIN VDD VSS sg13g2_dlygate4sd3_1
x6 net4 net3 VDD VSS sg13g2_dlygate4sd2_1
.ends

* expanding   symbol:  PD.sym # of pins=5
** sym_path: /home/designer/designs/libs/IHP__MPC0349/dependencies/IHP__QDLL6501/QDLL6501-main/schematic/xschem/PD.sym
** sch_path: /home/designer/designs/libs/IHP__MPC0349/dependencies/IHP__QDLL6501/QDLL6501-main/schematic/xschem/PD.sch
.subckt PD VDD VSS PDIN1 PDOUT PDIN2
*.iopin VDD
*.iopin VSS
*.opin PDOUT
*.ipin PDIN1
*.ipin PDIN2
x1 PDOUT PDIN1 PDIN2 VDD VSS sg13g2_xor2_1
.ends

* expanding   symbol:  CP.sym # of pins=3
** sym_path: /home/designer/designs/libs/IHP__MPC0349/dependencies/IHP__QDLL6501/QDLL6501-main/schematic/xschem/CP.sym
** sch_path: /home/designer/designs/libs/IHP__MPC0349/dependencies/IHP__QDLL6501/QDLL6501-main/schematic/xschem/CP.sch
.subckt CP CPIN CPOUT VSS
*.iopin VSS
*.ipin CPIN
*.opin CPOUT
XC1 CPOUT VSS cap_cmim w=60e-6 l=20e-6 m=1 mm_ok=1
x1 CPOUT CPIN VSS RES
.ends

* expanding   symbol:  sg13g2_antennanp.sym # of pins=1
** sym_path: /opt/pdks/ihp-sg13g2/libs.ref/sg13g2_stdcell/sym/xschem/sg13g2_antennanp.sym
** sch_path: /opt/pdks/ihp-sg13g2/libs.ref/sg13g2_stdcell/sch/xschem/sg13g2_antennanp.sch
.subckt sg13g2_antennanp A VDD VSS

*.ipin A
XD1 VSS A dantenna l=0.78u w=0.78u
XD2 A VDD dpantenna l=1.34u w=1.05u
.ends

* expanding   symbol:  sg13g2_inv_2.sym # of pins=2
** sym_path: /opt/pdks/ihp-sg13g2/libs.ref/sg13g2_stdcell/sym/xschem/sg13g2_inv_2.sym
** sch_path: /opt/pdks/ihp-sg13g2/libs.ref/sg13g2_stdcell/sch/xschem/sg13g2_inv_2.sch
.subckt sg13g2_inv_2 Y A VDD VSS

*.opin Y
*.ipin A
XM1 Y A VSS VSS sg13_lv_nmos w=1.48u l=130.00n ng=2 m=1 mm_ok=1
XM2 Y A VDD VDD sg13_lv_pmos w=2.24u l=130.00n ng=2 m=1 mm_ok=1
.ends

* expanding   symbol:  sg13g2_inv_4.sym # of pins=2
** sym_path: /opt/pdks/ihp-sg13g2/libs.ref/sg13g2_stdcell/sym/xschem/sg13g2_inv_4.sym
** sch_path: /opt/pdks/ihp-sg13g2/libs.ref/sg13g2_stdcell/sch/xschem/sg13g2_inv_4.sch
.subckt sg13g2_inv_4 Y A VDD VSS

*.ipin A
*.opin Y
XM1 Y A VSS VSS sg13_lv_nmos w=2.96u l=130.00n ng=4 m=1 mm_ok=1
XM2 Y A VDD VDD sg13_lv_pmos w=4.48u l=130.00n ng=4 m=1 mm_ok=1
.ends

* expanding   symbol:  sg13g2_inv_8.sym # of pins=2
** sym_path: /opt/pdks/ihp-sg13g2/libs.ref/sg13g2_stdcell/sym/xschem/sg13g2_inv_8.sym
** sch_path: /opt/pdks/ihp-sg13g2/libs.ref/sg13g2_stdcell/sch/xschem/sg13g2_inv_8.sch
.subckt sg13g2_inv_8 Y A VDD VSS

*.opin Y
*.ipin A
XM1 Y A VSS VSS sg13_lv_nmos w=5.92u l=130.00n ng=8 m=1 mm_ok=1
XM2 Y A VDD VDD sg13_lv_pmos w=8.96u l=130.00n ng=8 m=1 mm_ok=1
.ends

* expanding   symbol:  sg13g2_inv_16.sym # of pins=2
** sym_path: /opt/pdks/ihp-sg13g2/libs.ref/sg13g2_stdcell/sym/xschem/sg13g2_inv_16.sym
** sch_path: /opt/pdks/ihp-sg13g2/libs.ref/sg13g2_stdcell/sch/xschem/sg13g2_inv_16.sch
.subckt sg13g2_inv_16 Y A VDD VSS

*.opin Y
*.ipin A
XM1 Y A VSS VSS sg13_lv_nmos w=11.84u l=130.00n ng=16 m=1 mm_ok=1
XM2 Y A VDD VDD sg13_lv_pmos w=17.92u l=130.00n ng=16 m=1 mm_ok=1
.ends

* expanding   symbol:  sg13g2_dlygate4sd3_1.sym # of pins=2
** sym_path: /opt/pdks/ihp-sg13g2/libs.ref/sg13g2_stdcell/sym/xschem/sg13g2_dlygate4sd3_1.sym
** sch_path: /opt/pdks/ihp-sg13g2/libs.ref/sg13g2_stdcell/sch/xschem/sg13g2_dlygate4sd3_1.sch
.subckt sg13g2_dlygate4sd3_1 X A VDD VSS

*.ipin A
*.opin X
XM1 net3 A VSS VSS sg13_lv_nmos w=420.00n l=130.00n ng=1 m=1 mm_ok=1
XM2 net1 net3 VSS VSS sg13_lv_nmos w=420.00n l=500.0n ng=1 m=1 mm_ok=1
XM3 net2 net1 VSS VSS sg13_lv_nmos w=420.00n l=500.0n ng=1 m=1 mm_ok=1
XM4 X net2 VSS VSS sg13_lv_nmos w=740.00n l=130.00n ng=1 m=1 mm_ok=1
XM5 net3 A VDD VDD sg13_lv_pmos w=420.00n l=130.00n ng=1 m=1 mm_ok=1
XM6 net1 net3 VDD VDD sg13_lv_pmos w=1.000u l=500.0n ng=1 m=1 mm_ok=1
XM7 net2 net1 VDD VDD sg13_lv_pmos w=1.000u l=500.0n ng=1 m=1 mm_ok=1
XM8 X net2 VDD VDD sg13_lv_pmos w=1.12u l=130.00n ng=1 m=1 mm_ok=1
.ends

* expanding   symbol:  sg13g2_dlygate4sd2_1.sym # of pins=2
** sym_path: /opt/pdks/ihp-sg13g2/libs.ref/sg13g2_stdcell/sym/xschem/sg13g2_dlygate4sd2_1.sym
** sch_path: /opt/pdks/ihp-sg13g2/libs.ref/sg13g2_stdcell/sch/xschem/sg13g2_dlygate4sd2_1.sch
.subckt sg13g2_dlygate4sd2_1 X A VDD VSS

*.ipin A
*.opin X
XM1 net2 A VSS VSS sg13_lv_nmos w=420.00n l=130.00n ng=1 m=1 mm_ok=1
XM2 net1 net2 VSS VSS sg13_lv_nmos w=420.00n l=180.00n ng=1 m=1 mm_ok=1
XM3 net3 net1 VSS VSS sg13_lv_nmos w=420.00n l=180.00n ng=1 m=1 mm_ok=1
XM4 X net3 VSS VSS sg13_lv_nmos w=740.00n l=130.00n ng=1 m=1 mm_ok=1
XM5 net2 A VDD VDD sg13_lv_pmos w=420.00n l=130.00n ng=1 m=1 mm_ok=1
XM6 net1 net2 VDD VDD sg13_lv_pmos w=1.000u l=250.00n ng=1 m=1 mm_ok=1
XM7 net3 net1 VDD VDD sg13_lv_pmos w=1.000u l=250.00n ng=1 m=1 mm_ok=1
XM8 X net3 VDD VDD sg13_lv_pmos w=1.12u l=130.00n ng=1 m=1 mm_ok=1
.ends

* expanding   symbol:  sg13g2_xor2_1.sym # of pins=3
** sym_path: /opt/pdks/ihp-sg13g2/libs.ref/sg13g2_stdcell/sym/xschem/sg13g2_xor2_1.sym
** sch_path: /opt/pdks/ihp-sg13g2/libs.ref/sg13g2_stdcell/sch/xschem/sg13g2_xor2_1.sch
.subckt sg13g2_xor2_1 X A B VDD VSS

*.opin X
*.ipin B
*.ipin A
XM1 net1 A VSS VSS sg13_lv_nmos w=550.00n l=130.00n ng=1 m=1 mm_ok=1
XM2 net1 B VSS VSS sg13_lv_nmos w=550.00n l=130.00n ng=1 m=1 mm_ok=1
XM3 X net1 VSS VSS sg13_lv_nmos w=740.00n l=130.00n ng=1 m=1 mm_ok=1
XM4 X B net3 VSS sg13_lv_nmos w=740.00n l=130.00n ng=1 m=1 mm_ok=1
XM5 net3 A VSS VSS sg13_lv_nmos w=740.00n l=130.00n ng=1 m=1 mm_ok=1
XM6 net4 A VDD VDD sg13_lv_pmos w=1.000u l=130.00n ng=1 m=1 mm_ok=1
XM7 net1 B net4 VDD sg13_lv_pmos w=1.000u l=130.00n ng=1 m=1 mm_ok=1
XM8 net2 A VDD VDD sg13_lv_pmos w=1.12u l=130.00n ng=1 m=1 mm_ok=1
XM9 X net1 net2 VDD sg13_lv_pmos w=1.12u l=130.00n ng=1 m=1 mm_ok=1
XM10 net2 B VDD VDD sg13_lv_pmos w=1.12u l=130.00n ng=1 m=1 mm_ok=1
.ends

* expanding   symbol:  RES.sym # of pins=3
** sym_path: /home/designer/designs/libs/IHP__MPC0349/dependencies/IHP__QDLL6501/QDLL6501-main/schematic/xschem/RES.sym
** sch_path: /home/designer/designs/libs/IHP__MPC0349/dependencies/IHP__QDLL6501/QDLL6501-main/schematic/xschem/RES.sch
.subckt RES ROUT RIN VSS
*.ipin RIN
*.opin ROUT
*.iopin VSS
XR13 net1 RIN VSS rppd w=1e-6 l=10e-6 m=1 b=0 mm_ok=1
XR1 net2 net1 VSS rppd w=1e-6 l=10e-6 m=1 b=0 mm_ok=1
XR2 net3 net2 VSS rppd w=1e-6 l=10e-6 m=1 b=0 mm_ok=1
XR3 net4 net3 VSS rppd w=1e-6 l=10e-6 m=1 b=0 mm_ok=1
XR4 net5 net4 VSS rppd w=1e-6 l=10e-6 m=1 b=0 mm_ok=1
XR5 net6 net5 VSS rppd w=1e-6 l=10e-6 m=1 b=0 mm_ok=1
XR6 net7 net6 VSS rppd w=1e-6 l=10e-6 m=1 b=0 mm_ok=1
XR7 net8 net7 VSS rppd w=1e-6 l=10e-6 m=1 b=0 mm_ok=1
XR8 net9 net8 VSS rppd w=1e-6 l=10e-6 m=1 b=0 mm_ok=1
XR9 net10 net9 VSS rppd w=1e-6 l=10e-6 m=1 b=0 mm_ok=1
XR10 net11 net10 VSS rppd w=1e-6 l=10e-6 m=1 b=0 mm_ok=1
XR11 ROUT net11 VSS rppd w=1e-6 l=10e-6 m=1 b=0 mm_ok=1
.ends

.end
